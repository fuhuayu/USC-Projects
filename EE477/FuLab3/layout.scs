// Generated for: spectre
// Generated on: Dec  6 12:51:50 2016
// Design library name: lab3
// Design cell name: neuron
// Design view name: extracted
simulator lang=spectre
global 0
include "/home/scf-30/huayufu/cds/tsmc.spice"

vec_include "/home/scf-30/huayufu/cds/lab3/neuron.vec"

// Library name: lab3
// Cell name: neuron
// View name: extracted
\+109 (vdd! Q2 46 vdd!) tsmc20P w=1.6e-06 l=2e-07 as=8e-13 ad=8e-13 \
        ps=2.6e-06 pd=2.6e-06 m=1 region=sat
\+108 (Q2 48 vdd! vdd!) tsmc20P w=1.6e-06 l=2e-07 as=8e-13 ad=8e-13 \
        ps=2.6e-06 pd=2.6e-06 m=1 region=sat
\+107 (vdd! Q1 45 vdd!) tsmc20P w=1.6e-06 l=2e-07 as=8e-13 ad=8e-13 \
        ps=2.6e-06 pd=2.6e-06 m=1 region=sat
\+106 (Q1 47 vdd! vdd!) tsmc20P w=1.6e-06 l=2e-07 as=8e-13 ad=8e-13 \
        ps=2.6e-06 pd=2.6e-06 m=1 region=sat
\+100 (32 44 vdd! vdd!) tsmc20P w=1.6e-06 l=2e-07 as=8e-13 ad=8e-13 \
        ps=2.6e-06 pd=2.6e-06 m=1 region=sat
\+98 (31 43 vdd! vdd!) tsmc20P w=1.6e-06 l=2e-07 as=8e-13 ad=8e-13 \
        ps=2.6e-06 pd=2.6e-06 m=1 region=sat
\+83 (30 clock vdd! vdd!) tsmc20P w=1.6e-06 l=2e-07 as=8e-13 ad=8e-13 \
        ps=2.6e-06 pd=2.6e-06 m=1 region=sat
\+82 (29 Load vdd! vdd!) tsmc20P w=1.6e-06 l=2e-07 as=8e-13 ad=8e-13 \
        ps=2.6e-06 pd=2.6e-06 m=1 region=sat
\+80 (vdd! Q1 25 vdd!) tsmc20P w=1.6e-06 l=2e-07 as=8e-13 ad=8e-13 \
        ps=2.6e-06 pd=2.6e-06 m=1 region=sat
\+79 (vdd! AP 26 vdd!) tsmc20P w=1.6e-06 l=2e-07 as=8e-13 ad=8e-13 \
        ps=2.6e-06 pd=2.6e-06 m=1 region=sat
\+78 (AP 27 vdd! vdd!) tsmc20P w=1.6e-06 l=2e-07 as=8e-13 ad=8e-13 \
        ps=2.6e-06 pd=2.6e-06 m=1 region=sat
\+77 (vdd! Q2 28 vdd!) tsmc20P w=1.6e-06 l=2e-07 as=8e-13 ad=8e-13 \
        ps=2.6e-06 pd=2.6e-06 m=1 region=sat
\+70 (12 24 vdd! vdd!) tsmc20P w=1.6e-06 l=2e-07 as=8e-13 ad=8e-13 \
        ps=2.6e-06 pd=2.6e-06 m=1 region=sat
\+64 (vdd! D 19 vdd!) tsmc20P w=1.6e-06 l=2e-07 as=8e-13 ad=8e-13 \
        ps=2.6e-06 pd=2.6e-06 m=1 region=sat
\+59 (vdd! I 15 vdd!) tsmc20P w=1.6e-06 l=2e-07 as=8e-13 ad=8e-13 \
        ps=2.6e-06 pd=2.6e-06 m=1 region=sat
\+500 (gnd! 48) capacitor c=2.328e-17 m=1
\+499 (gnd! 47) capacitor c=2.328e-17 m=1
\+498 (gnd! 44) capacitor c=2.328e-17 m=1
\+497 (gnd! 43) capacitor c=2.328e-17 m=1
\+496 (gnd! 42) capacitor c=7.76e-17 m=1
\+495 (gnd! 41) capacitor c=7.76e-17 m=1
\+494 (gnd! 40) capacitor c=7.76e-17 m=1
\+493 (gnd! 39) capacitor c=7.76e-17 m=1
\+492 (gnd! 34) capacitor c=6.111e-17 m=1
\+491 (gnd! 33) capacitor c=6.111e-17 m=1
\+490 (gnd! 30) capacitor c=1.746e-16 m=1
\+489 (gnd! 29) capacitor c=2.91e-17 m=1
\+488 (gnd! 28) capacitor c=5.82e-17 m=1
\+487 (gnd! 27) capacitor c=2.328e-17 m=1
\+486 (gnd! 24) capacitor c=2.328e-17 m=1
\+485 (gnd! 21) capacitor c=7.76e-17 m=1
\+484 (gnd! 19) capacitor c=5.82e-17 m=1
\+483 (gnd! 18) capacitor c=7.76e-17 m=1
\+482 (gnd! 15) capacitor c=2.91e-17 m=1
\+481 (gnd! 14) capacitor c=6.111e-17 m=1
\+480 (Q2 gnd!) capacitor c=1.0476e-16 m=1
\+479 (Q1 gnd!) capacitor c=4.656e-17 m=1
\+478 (Load gnd!) capacitor c=5.238e-17 m=1
\+477 (I gnd!) capacitor c=5.238e-17 m=1
\+476 (D gnd!) capacitor c=8.148e-17 m=1
\+475 (clock gnd!) capacitor c=1.9788e-16 m=1
\+474 (vdd! 48) capacitor c=2.328e-17 m=1
\+473 (vdd! 47) capacitor c=2.328e-17 m=1
\+472 (vdd! 44) capacitor c=2.328e-17 m=1
\+471 (vdd! 43) capacitor c=2.328e-17 m=1
\+470 (vdd! 30) capacitor c=1.2804e-16 m=1
\+469 (vdd! 29) capacitor c=2.134e-17 m=1
\+468 (vdd! 28) capacitor c=4.268e-17 m=1
\+467 (vdd! 27) capacitor c=2.328e-17 m=1
\+466 (vdd! 24) capacitor c=2.328e-17 m=1
\+465 (vdd! 19) capacitor c=4.268e-17 m=1
\+464 (vdd! 15) capacitor c=2.134e-17 m=1
\+463 (vdd! gnd!) capacitor c=1.0088e-16 m=1
\+462 (vdd! Q2) capacitor c=8.924e-17 m=1
\+461 (vdd! Q1) capacitor c=4.656e-17 m=1
\+460 (vdd! Load) capacitor c=4.462e-17 m=1
\+459 (vdd! I) capacitor c=4.462e-17 m=1
\+458 (vdd! D) capacitor c=6.596e-17 m=1
\+457 (vdd! clock) capacitor c=1.5132e-16 m=1
\+456 (AP gnd!) capacitor c=2.328e-17 m=1
\+455 (AP vdd!) capacitor c=2.328e-17 m=1
\+454 (reset gnd!) capacitor c=1.8333e-16 m=1
\+453 (reset vdd!) capacitor c=4.656e-17 m=1
\+452 (34 40) capacitor c=6.966e-17 m=1
\+451 (33 39) capacitor c=6.966e-17 m=1
\+450 (14 18) capacitor c=6.966e-17 m=1
\+449 (gnd! 48) capacitor c=3e-16 m=1
\+448 (gnd! 47) capacitor c=3e-16 m=1
\+447 (gnd! 46) capacitor c=1.8598e-16 m=1
\+446 (gnd! 45) capacitor c=1.8598e-16 m=1
\+445 (gnd! 44) capacitor c=2.9052e-16 m=1
\+444 (gnd! 43) capacitor c=2.9052e-16 m=1
\+443 (gnd! 42) capacitor c=3e-16 m=1
\+442 (gnd! 41) capacitor c=3e-16 m=1
\+441 (gnd! 40) capacitor c=1.8476e-16 m=1
\+440 (gnd! 39) capacitor c=1.8476e-16 m=1
\+439 (gnd! 38) capacitor c=3.3479e-16 m=1
\+438 (gnd! 36) capacitor c=3.3479e-16 m=1
\+437 (gnd! 34) capacitor c=3e-16 m=1
\+436 (gnd! 33) capacitor c=3e-16 m=1
\+435 (gnd! 32) capacitor c=3.2389e-16 m=1
\+434 (gnd! 31) capacitor c=3.332e-16 m=1
\+433 (gnd! 30) capacitor c=3.084e-17 m=1
\+432 (gnd! 29) capacitor c=3.084e-17 m=1
\+431 (gnd! 28) capacitor c=3.084e-17 m=1
\+430 (gnd! 27) capacitor c=3e-16 m=1
\+429 (gnd! 26) capacitor c=1.8598e-16 m=1
\+428 (gnd! 25) capacitor c=1.8084e-16 m=1
\+427 (gnd! 24) capacitor c=2.9052e-16 m=1
\+426 (gnd! 23) capacitor c=4.4646e-16 m=1
\+425 (gnd! 22) capacitor c=4.7448e-16 m=1
\+424 (gnd! 21) capacitor c=3e-16 m=1
\+423 (gnd! 20) capacitor c=5.9292e-16 m=1
\+422 (gnd! 19) capacitor c=3.084e-17 m=1
\+421 (gnd! 18) capacitor c=1.8476e-16 m=1
\+420 (gnd! 17) capacitor c=3.3479e-16 m=1
\+419 (gnd! 15) capacitor c=3.084e-17 m=1
\+418 (gnd! 14) capacitor c=3e-16 m=1
\+417 (gnd! 13) capacitor c=4.5e-16 m=1
\+416 (gnd! 12) capacitor c=3.332e-16 m=1
\+415 (gnd! 11) capacitor c=4.792e-16 m=1
\+414 (Q2 gnd!) capacitor c=3.084e-17 m=1
\+413 (Q1 gnd!) capacitor c=1.773e-16 m=1
\+412 (D gnd!) capacitor c=1.7244e-16 m=1
\+411 (vdd! 48) capacitor c=8.46e-17 m=1
\+410 (vdd! 47) capacitor c=8.46e-17 m=1
\+409 (vdd! 46) capacitor c=7.71e-17 m=1
\+408 (vdd! 45) capacitor c=7.71e-17 m=1
\+407 (vdd! 44) capacitor c=8.152e-17 m=1
\+406 (vdd! 43) capacitor c=8.152e-17 m=1
\+405 (vdd! 42) capacitor c=8.46e-17 m=1
\+404 (vdd! 41) capacitor c=8.46e-17 m=1
\+403 (vdd! 40) capacitor c=6.168e-17 m=1
\+402 (vdd! 39) capacitor c=6.168e-17 m=1
\+401 (vdd! 38) capacitor c=7.314e-17 m=1
\+400 (vdd! 36) capacitor c=7.314e-17 m=1
\+399 (vdd! 34) capacitor c=8.46e-17 m=1
\+398 (vdd! 33) capacitor c=8.46e-17 m=1
\+397 (vdd! 32) capacitor c=1.6475e-16 m=1
\+396 (vdd! 31) capacitor c=1.1544e-16 m=1
\+395 (vdd! 30) capacitor c=3.084e-17 m=1
\+394 (vdd! 29) capacitor c=3.084e-17 m=1
\+393 (vdd! 28) capacitor c=3.084e-17 m=1
\+392 (vdd! 27) capacitor c=8.46e-17 m=1
\+391 (vdd! 26) capacitor c=7.71e-17 m=1
\+390 (vdd! 25) capacitor c=7.314e-17 m=1
\+389 (vdd! 24) capacitor c=8.152e-17 m=1
\+388 (vdd! 23) capacitor c=1.269e-16 m=1
\+387 (vdd! 22) capacitor c=1.269e-16 m=1
\+386 (vdd! 21) capacitor c=8.46e-17 m=1
\+385 (vdd! 20) capacitor c=1.692e-16 m=1
\+384 (vdd! 19) capacitor c=3.084e-17 m=1
\+383 (vdd! 18) capacitor c=6.168e-17 m=1
\+382 (vdd! 17) capacitor c=7.314e-17 m=1
\+381 (vdd! 15) capacitor c=3.084e-17 m=1
\+380 (vdd! 14) capacitor c=8.46e-17 m=1
\+379 (vdd! 13) capacitor c=1.269e-16 m=1
\+378 (vdd! 12) capacitor c=1.1544e-16 m=1
\+377 (vdd! 11) capacitor c=1.3044e-16 m=1
\+376 (vdd! gnd!) capacitor c=2.3824e-15 m=1
\+375 (vdd! Q2) capacitor c=3.084e-17 m=1
\+374 (vdd! Q1) capacitor c=7.314e-17 m=1
\+373 (vdd! D) capacitor c=8.982e-17 m=1
\+372 (AP gnd!) capacitor c=3.084e-17 m=1
\+371 (AP vdd!) capacitor c=3.084e-17 m=1
\+370 (reset 40) capacitor c=6.966e-17 m=1
\+369 (reset 39) capacitor c=6.966e-17 m=1
\+368 (reset 18) capacitor c=6.966e-17 m=1
\+367 (46 48) capacitor c=6.186e-17 m=1
\+366 (45 47) capacitor c=6.186e-17 m=1
\+365 (38 40) capacitor c=6.186e-17 m=1
\+364 (36 39) capacitor c=6.186e-17 m=1
\+363 (32 44) capacitor c=3.2263e-16 m=1
\+362 (32 42) capacitor c=6.186e-17 m=1
\+361 (32 34) capacitor c=7.268e-17 m=1
\+360 (31 43) capacitor c=3.2263e-16 m=1
\+359 (31 41) capacitor c=6.186e-17 m=1
\+358 (31 33) capacitor c=7.268e-17 m=1
\+357 (30 40) capacitor c=2.69305e-16 m=1
\+356 (30 38) capacitor c=1.2372e-16 m=1
\+355 (30 36) capacitor c=1.2372e-16 m=1
\+354 (30 32) capacitor c=6.186e-17 m=1
\+353 (30 31) capacitor c=6.186e-17 m=1
\+352 (27 29) capacitor c=1.3385e-16 m=1
\+351 (26 27) capacitor c=6.186e-17 m=1
\+350 (25 28) capacitor c=7.325e-17 m=1
\+349 (24 29) capacitor c=1.3385e-16 m=1
\+348 (23 28) capacitor c=3.896e-17 m=1
\+347 (22 28) capacitor c=3.896e-17 m=1
\+346 (22 23) capacitor c=9.489e-17 m=1
\+345 (21 29) capacitor c=9.489e-17 m=1
\+344 (20 22) capacitor c=2.8467e-16 m=1
\+343 (19 22) capacitor c=3.896e-17 m=1
\+342 (18 29) capacitor c=1.465e-16 m=1
\+341 (17 30) capacitor c=1.2372e-16 m=1
\+340 (17 18) capacitor c=6.186e-17 m=1
\+339 (14 29) capacitor c=1.33898e-16 m=1
\+338 (13 19) capacitor c=3.896e-17 m=1
\+337 (12 30) capacitor c=6.186e-17 m=1
\+336 (12 29) capacitor c=3.1081e-16 m=1
\+335 (12 24) capacitor c=3.2263e-16 m=1
\+334 (12 21) capacitor c=6.186e-17 m=1
\+333 (12 14) capacitor c=7.268e-17 m=1
\+332 (11 29) capacitor c=4.24323e-16 m=1
\+331 (gnd! 48) capacitor c=5.8004e-16 m=1
\+330 (gnd! 47) capacitor c=5.8004e-16 m=1
\+329 (gnd! 46) capacitor c=1.8655e-16 m=1
\+328 (gnd! 45) capacitor c=1.8655e-16 m=1
\+327 (gnd! 44) capacitor c=2.58825e-16 m=1
\+326 (gnd! 43) capacitor c=2.58825e-16 m=1
\+325 (gnd! 42) capacitor c=6.2106e-16 m=1
\+324 (gnd! 41) capacitor c=6.2106e-16 m=1
\+323 (gnd! 40) capacitor c=5.5828e-16 m=1
\+322 (gnd! 39) capacitor c=5.5828e-16 m=1
\+321 (gnd! 34) capacitor c=4.4705e-16 m=1
\+320 (gnd! 33) capacitor c=4.4705e-16 m=1
\+319 (gnd! 32) capacitor c=4.7128e-16 m=1
\+318 (gnd! 31) capacitor c=4.7128e-16 m=1
\+317 (gnd! 30) capacitor c=2.48704e-15 m=1
\+316 (gnd! 29) capacitor c=2.4745e-16 m=1
\+315 (gnd! 27) capacitor c=5.8004e-16 m=1
\+314 (gnd! 26) capacitor c=1.8655e-16 m=1
\+313 (gnd! 25) capacitor c=2.3714e-16 m=1
\+312 (gnd! 24) capacitor c=2.58825e-16 m=1
\+311 (gnd! 23) capacitor c=2.7791e-16 m=1
\+310 (gnd! 22) capacitor c=5.6576e-16 m=1
\+309 (gnd! 21) capacitor c=6.2106e-16 m=1
\+308 (gnd! 20) capacitor c=1.8594e-16 m=1
\+307 (gnd! 18) capacitor c=5.5828e-16 m=1
\+306 (gnd! 14) capacitor c=4.4705e-16 m=1
\+305 (gnd! 13) capacitor c=1.738e-16 m=1
\+304 (gnd! 12) capacitor c=3.2861e-16 m=1
\+303 (Q2 28) capacitor c=6.186e-17 m=1
\+302 (Q2 25) capacitor c=1.0082e-16 m=1
\+301 (Q2 23) capacitor c=6.186e-17 m=1
\+300 (Q2 22) capacitor c=3.896e-17 m=1
\+299 (Q2 20) capacitor c=1.0082e-16 m=1
\+298 (Q2 gnd!) capacitor c=1.51363e-15 m=1
\+297 (Q1 22) capacitor c=9.489e-17 m=1
\+296 (Q1 gnd!) capacitor c=9.3442e-16 m=1
\+295 (Load 29) capacitor c=3.896e-17 m=1
\+294 (I 15) capacitor c=6.186e-17 m=1
\+293 (I 11) capacitor c=5.6666e-16 m=1
\+292 (I gnd!) capacitor c=5.9851e-16 m=1
\+291 (D 23) capacitor c=6.186e-17 m=1
\+290 (D 22) capacitor c=1.6268e-16 m=1
\+289 (D 13) capacitor c=6.224e-17 m=1
\+288 (D gnd!) capacitor c=1.91175e-15 m=1
\+287 (clock 29) capacitor c=7.792e-17 m=1
\+286 (vdd! 46) capacitor c=7.992e-17 m=1
\+285 (vdd! 45) capacitor c=7.992e-17 m=1
\+284 (vdd! 44) capacitor c=8.9025e-17 m=1
\+283 (vdd! 43) capacitor c=8.9025e-17 m=1
\+282 (vdd! 32) capacitor c=2.4233e-16 m=1
\+281 (vdd! 31) capacitor c=2.4233e-16 m=1
\+280 (vdd! 30) capacitor c=6.8939e-16 m=1
\+279 (vdd! 29) capacitor c=7.7782e-16 m=1
\+278 (vdd! 26) capacitor c=7.992e-17 m=1
\+277 (vdd! 24) capacitor c=8.9025e-17 m=1
\+276 (vdd! 22) capacitor c=2.1852e-16 m=1
\+275 (vdd! 12) capacitor c=2.4195e-16 m=1
\+274 (vdd! gnd!) capacitor c=7.23e-17 m=1
\+273 (vdd! Q2) capacitor c=2.14065e-16 m=1
\+272 (vdd! Q1) capacitor c=6.189e-17 m=1
\+271 (vdd! I) capacitor c=1.3981e-16 m=1
\+270 (vdd! D) capacitor c=9.179e-17 m=1
\+269 (AP 29) capacitor c=7.325e-17 m=1
\+268 (AP gnd!) capacitor c=4.0088e-16 m=1
\+267 (reset 29) capacitor c=3.896e-17 m=1
\+266 (32 40) capacitor c=2.0985e-17 m=1
\+265 (32 34) capacitor c=8.698e-17 m=1
\+264 (31 39) capacitor c=4.197e-17 m=1
\+263 (31 33) capacitor c=8.698e-17 m=1
\+262 (30 46) capacitor c=4.197e-17 m=1
\+261 (30 45) capacitor c=4.197e-17 m=1
\+260 (30 44) capacitor c=1.7092e-16 m=1
\+259 (30 43) capacitor c=1.7092e-16 m=1
\+258 (30 42) capacitor c=1.2895e-16 m=1
\+257 (30 41) capacitor c=1.2895e-16 m=1
\+256 (30 32) capacitor c=8.642e-17 m=1
\+255 (30 31) capacitor c=2.798e-17 m=1
\+254 (26 30) capacitor c=4.197e-17 m=1
\+253 (25 28) capacitor c=1.0041e-16 m=1
\+252 (24 30) capacitor c=1.7092e-16 m=1
\+251 (23 28) capacitor c=4.197e-17 m=1
\+250 (21 30) capacitor c=1.2895e-16 m=1
\+249 (20 28) capacitor c=1.1069e-16 m=1
\+248 (20 23) capacitor c=5.844e-17 m=1
\+247 (19 23) capacitor c=4.197e-17 m=1
\+246 (19 22) capacitor c=8.394e-17 m=1
\+245 (13 19) capacitor c=1.0041e-16 m=1
\+244 (13 15) capacitor c=1.25655e-16 m=1
\+243 (12 30) capacitor c=2.798e-17 m=1
\+242 (12 18) capacitor c=4.197e-17 m=1
\+241 (12 14) capacitor c=8.698e-17 m=1
\+240 (11 29) capacitor c=2.0236e-16 m=1
\+239 (gnd! 32) capacitor c=8.2721e-16 m=1
\+238 (gnd! 31) capacitor c=8.43695e-16 m=1
\+237 (gnd! 30) capacitor c=3.04422e-15 m=1
\+236 (gnd! 28) capacitor c=1.19945e-15 m=1
\+235 (gnd! 22) capacitor c=1.9596e-16 m=1
\+234 (gnd! 20) capacitor c=5.9921e-16 m=1
\+233 (gnd! 19) capacitor c=1.16469e-15 m=1
\+232 (gnd! 15) capacitor c=4.9365e-16 m=1
\+231 (gnd! 12) capacitor c=8.43695e-16 m=1
\+230 (Q2 28) capacitor c=1.837e-16 m=1
\+229 (Q2 25) capacitor c=5.844e-17 m=1
\+228 (Q2 20) capacitor c=5.844e-17 m=1
\+227 (Q2 gnd!) capacitor c=4.35583e-16 m=1
\+226 (Load 32) capacitor c=2.79525e-16 m=1
\+225 (Load 30) capacitor c=1.42597e-16 m=1
\+224 (Load 29) capacitor c=3.15705e-16 m=1
\+223 (Load 12) capacitor c=5.87e-17 m=1
\+222 (Load gnd!) capacitor c=7.88465e-16 m=1
\+221 (I 15) capacitor c=5.844e-17 m=1
\+220 (I 11) capacitor c=6.3412e-16 m=1
\+219 (I gnd!) capacitor c=2.19215e-16 m=1
\+218 (D 22) capacitor c=5.844e-17 m=1
\+217 (D 19) capacitor c=2.2373e-16 m=1
\+216 (D gnd!) capacitor c=1.30613e-15 m=1
\+215 (clock 48) capacitor c=1.4238e-16 m=1
\+214 (clock 47) capacitor c=1.4238e-16 m=1
\+213 (clock 44) capacitor c=7.051e-17 m=1
\+212 (clock 43) capacitor c=7.051e-17 m=1
\+211 (clock 42) capacitor c=4.275e-17 m=1
\+210 (clock 41) capacitor c=4.27175e-17 m=1
\+209 (clock 36) capacitor c=1.39718e-16 m=1
\+208 (clock 32) capacitor c=1.0851e-16 m=1
\+207 (clock 31) capacitor c=1.0825e-16 m=1
\+206 (clock 30) capacitor c=4.8045e-16 m=1
\+205 (clock 27) capacitor c=2.0406e-16 m=1
\+204 (clock 24) capacitor c=7.051e-17 m=1
\+203 (clock 21) capacitor c=4.249e-17 m=1
\+202 (clock 12) capacitor c=1.0825e-16 m=1
\+201 (clock gnd!) capacitor c=3.83837e-15 m=1
\+200 (vdd! 32) capacitor c=5.87e-17 m=1
\+199 (vdd! 31) capacitor c=5.87e-17 m=1
\+198 (vdd! 30) capacitor c=8.19375e-16 m=1
\+197 (vdd! 22) capacitor c=3.245e-17 m=1
\+196 (vdd! 19) capacitor c=1.68525e-16 m=1
\+195 (vdd! 15) capacitor c=3.2775e-17 m=1
\+194 (vdd! 11) capacitor c=1.3986e-16 m=1
\+193 (vdd! gnd!) capacitor c=1.07114e-15 m=1
\+192 (vdd! Q2) capacitor c=7.81175e-17 m=1
\+191 (vdd! Load) capacitor c=1.66132e-16 m=1
\+190 (vdd! I) capacitor c=2.6152e-16 m=1
\+189 (vdd! D) capacitor c=1.87598e-15 m=1
\+188 (vdd! clock) capacitor c=1.92795e-15 m=1
\+187 (AP gnd!) capacitor c=1.6976e-16 m=1
\+186 (AP clock) capacitor c=5.844e-17 m=1
\+185 (AP vdd!) capacitor c=2.6152e-16 m=1
\+184 (reset 40) capacitor c=5.844e-17 m=1
\+183 (reset 38) capacitor c=1.0369e-16 m=1
\+182 (reset 37) capacitor c=3.138e-17 m=1
\+181 (reset 32) capacitor c=2.854e-17 m=1
\+180 (reset 31) capacitor c=2.854e-17 m=1
\+179 (reset 12) capacitor c=2.854e-17 m=1
\+178 (reset gnd!) capacitor c=6.19405e-16 m=1
\+177 (reset vdd!) capacitor c=2.5732e-16 m=1
\+176 (30 40) capacitor c=2.342e-17 m=1
\+175 (30 38) capacitor c=4.161e-17 m=1
\+174 (30 34) capacitor c=4.161e-17 m=1
\+173 (27 30) capacitor c=4.161e-17 m=1
\+172 (26 30) capacitor c=4.898e-17 m=1
\+171 (gnd! 30) capacitor c=2.472e-16 m=1
\+170 (Q1 47) capacitor c=6.503e-17 m=1
\+169 (Q1 43) capacitor c=5.569e-17 m=1
\+168 (Q1 41) capacitor c=4.161e-17 m=1
\+167 (Q1 39) capacitor c=1.68083e-16 m=1
\+166 (Q1 33) capacitor c=4.858e-17 m=1
\+165 (Q1 31) capacitor c=2.50215e-16 m=1
\+164 (Q1 22) capacitor c=6.546e-17 m=1
\+163 (Q1 gnd!) capacitor c=5.4348e-16 m=1
\+162 (Load 30) capacitor c=6.546e-17 m=1
\+161 (Load 27) capacitor c=1.2269e-16 m=1
\+160 (Load 24) capacitor c=2.19495e-16 m=1
\+159 (Load 14) capacitor c=4.858e-17 m=1
\+158 (Load 12) capacitor c=5.76885e-16 m=1
\+157 (Load 11) capacitor c=8.2505e-17 m=1
\+156 (Load gnd!) capacitor c=4.4093e-16 m=1
\+155 (D Q1) capacitor c=6.546e-17 m=1
\+154 (clock 40) capacitor c=8.4335e-17 m=1
\+153 (clock 38) capacitor c=1.22915e-16 m=1
\+152 (clock 32) capacitor c=1.82625e-16 m=1
\+151 (clock 30) capacitor c=1.8566e-16 m=1
\+150 (clock gnd!) capacitor c=2.7105e-16 m=1
\+149 (clock Q1) capacitor c=1.3092e-16 m=1
\+148 (clock Load) capacitor c=1.9638e-16 m=1
\+147 (vdd! 30) capacitor c=4.91e-16 m=1
\+146 (vdd! Q1) capacitor c=2.4211e-16 m=1
\+145 (vdd! Load) capacitor c=1.3091e-16 m=1
\+144 (vdd! clock) capacitor c=1.1329e-16 m=1
\+143 (AP 30) capacitor c=8.888e-17 m=1
\+142 (AP Load) capacitor c=4.161e-17 m=1
\+141 (reset 40) capacitor c=4.161e-17 m=1
\+140 (reset 39) capacitor c=5.517e-17 m=1
\+139 (reset 36) capacitor c=1.0317e-16 m=1
\+138 (reset 35) capacitor c=3.118e-17 m=1
\+137 (reset 34) capacitor c=1.0617e-16 m=1
\+136 (reset 32) capacitor c=1.3092e-16 m=1
\+135 (reset 30) capacitor c=6.546e-17 m=1
\+134 (reset 29) capacitor c=2.4275e-17 m=1
\+133 (reset 27) capacitor c=1.202e-16 m=1
\+132 (reset 24) capacitor c=1.202e-16 m=1
\+131 (reset 21) capacitor c=4.161e-17 m=1
\+130 (reset 18) capacitor c=4.161e-17 m=1
\+129 (reset 12) capacitor c=6.5885e-17 m=1
\+128 (reset gnd!) capacitor c=1.22485e-15 m=1
\+127 (reset Load) capacitor c=9.585e-17 m=1
\+126 (reset clock) capacitor c=1.9638e-16 m=1
\+125 (reset vdd!) capacitor c=2.81803e-16 m=1
\+124 (reset AP) capacitor c=4.8885e-17 m=1
\+123 (Q2 48) capacitor c=6.694e-17 m=1
\+122 (Q2 44) capacitor c=6.694e-17 m=1
\+121 (Q2 42) capacitor c=4.356e-17 m=1
\+120 (Q2 40) capacitor c=5.922e-17 m=1
\+119 (Q2 34) capacitor c=6.694e-17 m=1
\+118 (Q2 32) capacitor c=7.848e-17 m=1
\+117 (Q2 30) capacitor c=3.736e-17 m=1
\+116 (Q2 29) capacitor c=1.7897e-16 m=1
\+115 (Q2 gnd!) capacitor c=2.32e-17 m=1
\+114 (D Q2) capacitor c=9.302e-17 m=1
\+113 (clock Q2) capacitor c=7.248e-17 m=1
\+112 (vdd! Q2) capacitor c=5.0002e-16 m=1
\+111 (AP Q2) capacitor c=2.133e-17 m=1
\+110 (reset Q2) capacitor c=9.372e-17 m=1
\+54 (gnd! Q2 46 gnd!) tsmc20N w=1.6e-06 l=2e-07 as=8e-13 ad=8e-13 \
        ps=2.6e-06 pd=2.6e-06 m=1 region=sat
\+53 (Q2 48 gnd! gnd!) tsmc20N w=1.6e-06 l=2e-07 as=8e-13 ad=8e-13 \
        ps=2.6e-06 pd=2.6e-06 m=1 region=sat
\+52 (gnd! Q1 45 gnd!) tsmc20N w=1.6e-06 l=2e-07 as=8e-13 ad=8e-13 \
        ps=2.6e-06 pd=2.6e-06 m=1 region=sat
\+51 (Q1 47 gnd! gnd!) tsmc20N w=1.6e-06 l=2e-07 as=8e-13 ad=8e-13 \
        ps=2.6e-06 pd=2.6e-06 m=1 region=sat
\+45 (32 44 gnd! gnd!) tsmc20N w=1.6e-06 l=2e-07 as=8e-13 ad=8e-13 \
        ps=2.6e-06 pd=2.6e-06 m=1 region=sat
\+43 (31 43 gnd! gnd!) tsmc20N w=1.6e-06 l=2e-07 as=8e-13 ad=8e-13 \
        ps=2.6e-06 pd=2.6e-06 m=1 region=sat
\+28 (30 clock gnd! gnd!) tsmc20N w=1.6e-06 l=2e-07 as=8e-13 ad=8e-13 \
        ps=2.6e-06 pd=2.6e-06 m=1 region=sat
\+27 (29 Load gnd! gnd!) tsmc20N w=1.6e-06 l=2e-07 as=8e-13 ad=8e-13 \
        ps=2.6e-06 pd=2.6e-06 m=1 region=sat
\+25 (gnd! Q1 25 gnd!) tsmc20N w=1.6e-06 l=2e-07 as=8e-13 ad=8e-13 \
        ps=2.6e-06 pd=2.6e-06 m=1 region=sat
\+24 (gnd! AP 26 gnd!) tsmc20N w=1.6e-06 l=2e-07 as=8e-13 ad=8e-13 \
        ps=2.6e-06 pd=2.6e-06 m=1 region=sat
\+23 (AP 27 gnd! gnd!) tsmc20N w=1.6e-06 l=2e-07 as=8e-13 ad=8e-13 \
        ps=2.6e-06 pd=2.6e-06 m=1 region=sat
\+22 (gnd! Q2 28 gnd!) tsmc20N w=1.6e-06 l=2e-07 as=8e-13 ad=8e-13 \
        ps=2.6e-06 pd=2.6e-06 m=1 region=sat
\+15 (12 24 gnd! gnd!) tsmc20N w=1.6e-06 l=2e-07 as=8e-13 ad=8e-13 \
        ps=2.6e-06 pd=2.6e-06 m=1 region=sat
\+9 (gnd! D 19 gnd!) tsmc20N w=1.6e-06 l=2e-07 as=8e-13 ad=8e-13 \
        ps=2.6e-06 pd=2.6e-06 m=1 region=sat
\+4 (gnd! I 15 gnd!) tsmc20N w=1.6e-06 l=2e-07 as=8e-13 ad=8e-13 \
        ps=2.6e-06 pd=2.6e-06 m=1 region=sat
\+50 (47 30 43 gnd!) tsmc20N w=4e-07 l=2e-07 as=2e-13 ad=2e-13 ps=1.4e-06 \
        pd=1.4e-06 m=1 region=sat
\+49 (48 clock 46 gnd!) tsmc20N w=4e-07 l=2e-07 as=2e-13 ad=2e-13 \
        ps=1.4e-06 pd=1.4e-06 m=1 region=sat
\+48 (48 30 44 gnd!) tsmc20N w=4e-07 l=2e-07 as=2e-13 ad=2e-13 ps=1.4e-06 \
        pd=1.4e-06 m=1 region=sat
\+47 (47 clock 45 gnd!) tsmc20N w=4e-07 l=2e-07 as=2e-13 ad=2e-13 \
        ps=1.4e-06 pd=1.4e-06 m=1 region=sat
\+46 (44 42 gnd! gnd!) tsmc20N w=4e-07 l=2e-07 as=2e-13 ad=2e-13 \
        ps=1.4e-06 pd=1.4e-06 m=1 region=sat
\+44 (43 41 gnd! gnd!) tsmc20N w=4e-07 l=2e-07 as=2e-13 ad=2e-13 \
        ps=1.4e-06 pd=1.4e-06 m=1 region=sat
\+42 (42 clock 38 gnd!) tsmc20N w=4e-07 l=2e-07 as=2e-13 ad=2e-13 \
        ps=1.4e-06 pd=1.4e-06 m=1 region=sat
\+41 (42 30 32 gnd!) tsmc20N w=4e-07 l=2e-07 as=2e-13 ad=2e-13 ps=1.4e-06 \
        pd=1.4e-06 m=1 region=sat
\+40 (41 clock 36 gnd!) tsmc20N w=4e-07 l=2e-07 as=2e-13 ad=2e-13 \
        ps=1.4e-06 pd=1.4e-06 m=1 region=sat
\+39 (41 30 31 gnd!) tsmc20N w=4e-07 l=2e-07 as=2e-13 ad=2e-13 ps=1.4e-06 \
        pd=1.4e-06 m=1 region=sat
\+38 (40 reset 37 gnd!) tsmc20N w=4e-07 l=2e-07 as=1.2e-13 ad=2e-13 \
        ps=6e-07 pd=1.4e-06 m=1 region=sat
\+37 (39 reset 35 gnd!) tsmc20N w=4e-07 l=2e-07 as=1.2e-13 ad=2e-13 \
        ps=6e-07 pd=1.4e-06 m=1 region=sat
\+36 (38 40 gnd! gnd!) tsmc20N w=4e-07 l=2e-07 as=2e-13 ad=2e-13 \
        ps=1.4e-06 pd=1.4e-06 m=1 region=sat
\+35 (37 34 gnd! gnd!) tsmc20N w=4e-07 l=2e-07 as=2e-13 ad=1.2e-13 \
        ps=1.4e-06 pd=6e-07 m=1 region=sat
\+34 (36 39 gnd! gnd!) tsmc20N w=4e-07 l=2e-07 as=2e-13 ad=2e-13 \
        ps=1.4e-06 pd=1.4e-06 m=1 region=sat
\+33 (35 33 gnd! gnd!) tsmc20N w=4e-07 l=2e-07 as=2e-13 ad=1.2e-13 \
        ps=1.4e-06 pd=6e-07 m=1 region=sat
\+32 (34 gnd! 32 gnd!) tsmc20N w=4e-07 l=2e-07 as=2e-13 ad=2e-13 \
        ps=1.4e-06 pd=1.4e-06 m=1 region=sat
\+31 (34 vdd! D gnd!) tsmc20N w=4e-07 l=2e-07 as=2e-13 ad=2e-13 ps=1.4e-06 \
        pd=1.4e-06 m=1 region=sat
\+30 (33 gnd! 31 gnd!) tsmc20N w=4e-07 l=2e-07 as=2e-13 ad=2e-13 \
        ps=1.4e-06 pd=1.4e-06 m=1 region=sat
\+29 (33 vdd! 22 gnd!) tsmc20N w=4e-07 l=2e-07 as=2e-13 ad=2e-13 \
        ps=1.4e-06 pd=1.4e-06 m=1 region=sat
\+26 (Q1 28 20 gnd!) tsmc20N w=4e-07 l=2e-07 as=2e-13 ad=2e-13 ps=1.4e-06 \
        pd=1.4e-06 m=1 region=sat
\+21 (gnd! Q2 20 gnd!) tsmc20N w=4e-07 l=2e-07 as=2e-13 ad=2e-13 \
        ps=1.4e-06 pd=1.4e-06 m=1 region=sat
\+20 (27 clock 26 gnd!) tsmc20N w=4e-07 l=2e-07 as=2e-13 ad=2e-13 \
        ps=1.4e-06 pd=1.4e-06 m=1 region=sat
\+19 (27 30 24 gnd!) tsmc20N w=4e-07 l=2e-07 as=2e-13 ad=2e-13 ps=1.4e-06 \
        pd=1.4e-06 m=1 region=sat
\+18 (25 Q2 23 gnd!) tsmc20N w=4e-07 l=2e-07 as=2e-13 ad=2e-13 ps=1.4e-06 \
        pd=1.4e-06 m=1 region=sat
\+17 (20 D 22 gnd!) tsmc20N w=4e-07 l=2e-07 as=2e-13 ad=2e-13 ps=1.4e-06 \
        pd=1.4e-06 m=1 region=sat
\+16 (24 21 gnd! gnd!) tsmc20N w=4e-07 l=2e-07 as=2e-13 ad=2e-13 \
        ps=1.4e-06 pd=1.4e-06 m=1 region=sat
\+14 (gnd! 28 23 gnd!) tsmc20N w=4e-07 l=2e-07 as=2e-13 ad=2e-13 \
        ps=1.4e-06 pd=1.4e-06 m=1 region=sat
\+13 (23 19 22 gnd!) tsmc20N w=4e-07 l=2e-07 as=2e-13 ad=2e-13 ps=1.4e-06 \
        pd=1.4e-06 m=1 region=sat
\+12 (21 clock 17 gnd!) tsmc20N w=4e-07 l=2e-07 as=2e-13 ad=2e-13 \
        ps=1.4e-06 pd=1.4e-06 m=1 region=sat
\+11 (21 30 12 gnd!) tsmc20N w=4e-07 l=2e-07 as=2e-13 ad=2e-13 ps=1.4e-06 \
        pd=1.4e-06 m=1 region=sat
\+10 (20 D 13 gnd!) tsmc20N w=4e-07 l=2e-07 as=2e-13 ad=2e-13 ps=1.4e-06 \
        pd=1.4e-06 m=1 region=sat
\+8 (18 reset 16 gnd!) tsmc20N w=4e-07 l=2e-07 as=1.2e-13 ad=2e-13 \
        ps=6e-07 pd=1.4e-06 m=1 region=sat
\+7 (17 18 gnd! gnd!) tsmc20N w=4e-07 l=2e-07 as=2e-13 ad=2e-13 ps=1.4e-06 \
        pd=1.4e-06 m=1 region=sat
\+6 (16 14 gnd! gnd!) tsmc20N w=4e-07 l=2e-07 as=2e-13 ad=1.2e-13 \
        ps=1.4e-06 pd=6e-07 m=1 region=sat
\+5 (gnd! 19 13 gnd!) tsmc20N w=4e-07 l=2e-07 as=2e-13 ad=2e-13 ps=1.4e-06 \
        pd=1.4e-06 m=1 region=sat
\+3 (14 29 12 gnd!) tsmc20N w=4e-07 l=2e-07 as=2e-13 ad=2e-13 ps=1.4e-06 \
        pd=1.4e-06 m=1 region=sat
\+2 (14 Load 11 gnd!) tsmc20N w=4e-07 l=2e-07 as=2e-13 ad=2e-13 ps=1.4e-06 \
        pd=1.4e-06 m=1 region=sat
\+1 (13 15 11 gnd!) tsmc20N w=4e-07 l=2e-07 as=2e-13 ad=2e-13 ps=1.4e-06 \
        pd=1.4e-06 m=1 region=sat
\+0 (gnd! I 11 gnd!) tsmc20N w=4e-07 l=2e-07 as=2e-13 ad=2e-13 ps=1.4e-06 \
        pd=1.4e-06 m=1 region=sat
\+105 (47 clock 43 vdd!) tsmc20P w=4e-07 l=2e-07 as=2e-13 ad=2e-13 \
        ps=1.4e-06 pd=1.4e-06 m=1 region=sat
\+104 (48 30 46 vdd!) tsmc20P w=4e-07 l=2e-07 as=2e-13 ad=2e-13 ps=1.4e-06 \
        pd=1.4e-06 m=1 region=sat
\+103 (48 clock 44 vdd!) tsmc20P w=4e-07 l=2e-07 as=2e-13 ad=2e-13 \
        ps=1.4e-06 pd=1.4e-06 m=1 region=sat
\+102 (47 30 45 vdd!) tsmc20P w=4e-07 l=2e-07 as=2e-13 ad=2e-13 ps=1.4e-06 \
        pd=1.4e-06 m=1 region=sat
\+101 (44 42 vdd! vdd!) tsmc20P w=4e-07 l=2e-07 as=2e-13 ad=2e-13 \
        ps=1.4e-06 pd=1.4e-06 m=1 region=sat
\+99 (43 41 vdd! vdd!) tsmc20P w=4e-07 l=2e-07 as=2e-13 ad=2e-13 \
        ps=1.4e-06 pd=1.4e-06 m=1 region=sat
\+97 (42 30 38 vdd!) tsmc20P w=4e-07 l=2e-07 as=2e-13 ad=2e-13 ps=1.4e-06 \
        pd=1.4e-06 m=1 region=sat
\+96 (42 clock 32 vdd!) tsmc20P w=4e-07 l=2e-07 as=2e-13 ad=2e-13 \
        ps=1.4e-06 pd=1.4e-06 m=1 region=sat
\+95 (41 30 36 vdd!) tsmc20P w=4e-07 l=2e-07 as=2e-13 ad=2e-13 ps=1.4e-06 \
        pd=1.4e-06 m=1 region=sat
\+94 (41 clock 31 vdd!) tsmc20P w=4e-07 l=2e-07 as=2e-13 ad=2e-13 \
        ps=1.4e-06 pd=1.4e-06 m=1 region=sat
\+91 (38 40 vdd! vdd!) tsmc20P w=4e-07 l=2e-07 as=2e-13 ad=2e-13 \
        ps=1.4e-06 pd=1.4e-06 m=1 region=sat
\+89 (36 39 vdd! vdd!) tsmc20P w=4e-07 l=2e-07 as=2e-13 ad=2e-13 \
        ps=1.4e-06 pd=1.4e-06 m=1 region=sat
\+87 (34 vdd! 32 vdd!) tsmc20P w=4e-07 l=2e-07 as=2e-13 ad=2e-13 \
        ps=1.4e-06 pd=1.4e-06 m=1 region=sat
\+86 (34 gnd! D vdd!) tsmc20P w=4e-07 l=2e-07 as=2e-13 ad=2e-13 ps=1.4e-06 \
        pd=1.4e-06 m=1 region=sat
\+85 (33 vdd! 31 vdd!) tsmc20P w=4e-07 l=2e-07 as=2e-13 ad=2e-13 \
        ps=1.4e-06 pd=1.4e-06 m=1 region=sat
\+84 (33 gnd! 22 vdd!) tsmc20P w=4e-07 l=2e-07 as=2e-13 ad=2e-13 \
        ps=1.4e-06 pd=1.4e-06 m=1 region=sat
\+81 (Q1 Q2 20 vdd!) tsmc20P w=4e-07 l=2e-07 as=2e-13 ad=2e-13 ps=1.4e-06 \
        pd=1.4e-06 m=1 region=sat
\+76 (gnd! 28 20 vdd!) tsmc20P w=4e-07 l=2e-07 as=2e-13 ad=2e-13 \
        ps=1.4e-06 pd=1.4e-06 m=1 region=sat
\+75 (27 30 26 vdd!) tsmc20P w=4e-07 l=2e-07 as=2e-13 ad=2e-13 ps=1.4e-06 \
        pd=1.4e-06 m=1 region=sat
\+74 (27 clock 24 vdd!) tsmc20P w=4e-07 l=2e-07 as=2e-13 ad=2e-13 \
        ps=1.4e-06 pd=1.4e-06 m=1 region=sat
\+73 (25 28 23 vdd!) tsmc20P w=4e-07 l=2e-07 as=2e-13 ad=2e-13 ps=1.4e-06 \
        pd=1.4e-06 m=1 region=sat
\+72 (20 19 22 vdd!) tsmc20P w=4e-07 l=2e-07 as=2e-13 ad=2e-13 ps=1.4e-06 \
        pd=1.4e-06 m=1 region=sat
\+71 (24 21 vdd! vdd!) tsmc20P w=4e-07 l=2e-07 as=2e-13 ad=2e-13 \
        ps=1.4e-06 pd=1.4e-06 m=1 region=sat
\+69 (gnd! Q2 23 vdd!) tsmc20P w=4e-07 l=2e-07 as=2e-13 ad=2e-13 \
        ps=1.4e-06 pd=1.4e-06 m=1 region=sat
\+68 (23 D 22 vdd!) tsmc20P w=4e-07 l=2e-07 as=2e-13 ad=2e-13 ps=1.4e-06 \
        pd=1.4e-06 m=1 region=sat
\+67 (21 30 17 vdd!) tsmc20P w=4e-07 l=2e-07 as=2e-13 ad=2e-13 ps=1.4e-06 \
        pd=1.4e-06 m=1 region=sat
\+66 (21 clock 12 vdd!) tsmc20P w=4e-07 l=2e-07 as=2e-13 ad=2e-13 \
        ps=1.4e-06 pd=1.4e-06 m=1 region=sat
\+65 (20 19 13 vdd!) tsmc20P w=4e-07 l=2e-07 as=2e-13 ad=2e-13 ps=1.4e-06 \
        pd=1.4e-06 m=1 region=sat
\+62 (17 18 vdd! vdd!) tsmc20P w=4e-07 l=2e-07 as=2e-13 ad=2e-13 \
        ps=1.4e-06 pd=1.4e-06 m=1 region=sat
\+60 (gnd! D 13 vdd!) tsmc20P w=4e-07 l=2e-07 as=2e-13 ad=2e-13 ps=1.4e-06 \
        pd=1.4e-06 m=1 region=sat
\+58 (14 Load 12 vdd!) tsmc20P w=4e-07 l=2e-07 as=2e-13 ad=2e-13 \
        ps=1.4e-06 pd=1.4e-06 m=1 region=sat
\+57 (14 29 11 vdd!) tsmc20P w=4e-07 l=2e-07 as=2e-13 ad=2e-13 ps=1.4e-06 \
        pd=1.4e-06 m=1 region=sat
\+56 (13 I 11 vdd!) tsmc20P w=4e-07 l=2e-07 as=2e-13 ad=2e-13 ps=1.4e-06 \
        pd=1.4e-06 m=1 region=sat
\+55 (gnd! 15 11 vdd!) tsmc20P w=4e-07 l=2e-07 as=2e-13 ad=2e-13 \
        ps=1.4e-06 pd=1.4e-06 m=1 region=sat
\+93 (40 reset vdd! vdd!) tsmc20P w=8.5e-07 l=2e-07 as=2.55e-13 \
        ad=4.25e-13 ps=6e-07 pd=1.85e-06 m=1 region=sat
\+92 (39 reset vdd! vdd!) tsmc20P w=8.5e-07 l=2e-07 as=2.55e-13 \
        ad=4.25e-13 ps=6e-07 pd=1.85e-06 m=1 region=sat
\+90 (vdd! 34 40 vdd!) tsmc20P w=8.5e-07 l=2e-07 as=4.25e-13 ad=2.55e-13 \
        ps=1.85e-06 pd=6e-07 m=1 region=sat
\+88 (vdd! 33 39 vdd!) tsmc20P w=8.5e-07 l=2e-07 as=4.25e-13 ad=2.55e-13 \
        ps=1.85e-06 pd=6e-07 m=1 region=sat
\+63 (18 reset vdd! vdd!) tsmc20P w=8.5e-07 l=2e-07 as=2.55e-13 \
        ad=4.25e-13 ps=6e-07 pd=1.85e-06 m=1 region=sat
\+61 (vdd! 14 18 vdd!) tsmc20P w=8.5e-07 l=2e-07 as=4.25e-13 ad=2.55e-13 \
        ps=1.85e-06 pd=6e-07 m=1 region=sat
include "./_graphical_stimuli.scs"
simulatorOptions options reltol=1e-3 vabstol=1e-6 iabstol=1e-12 temp=27 \
    tnom=27 scalem=1.0 scale=1.0 gmin=1e-12 rforce=1 maxnotes=5 maxwarns=5 \
    digits=5 cols=80 pivrel=1e-3 sensfile="../psf/sens.output" \
    checklimitdest=psf
tran tran stop=17.18n errpreset=moderate write="spectre.ic" \
    writefinal="spectre.fc" annotate=status maxiters=5
finalTimeOP info what=oppoint where=rawfile
modelParameter info what=models where=rawfile
element info what=inst where=rawfile
outputParameter info what=output where=rawfile
designParamVals info what=parameters where=rawfile
primitives info what=primitives where=rawfile
subckts info what=subckts  where=rawfile
saveOptions options save=allpub
