// Generated for: spectre
// Generated on: Nov 12 15:46:53 2016
// Design library name: lab1
// Design cell name: inv2test
// Design view name: extracted
simulator lang=spectre
global 0

// Library name: lab1
// Cell name: inv2test
// View name: extracted
\+3 (5 INV2OUT vdd! vdd!) tsmc20P w=4e-07 l=2e-07 as=2e-13 ad=2e-13 ps=1.4e-06 pd=1.4e-06 m=1 region=sat
\+13 (A gnd!) capacitor c=2.328e-17 m=1
\+12 (vdd! A) capacitor c=2.328e-17 m=1
\+11 (INV2OUT gnd!) capacitor c=8.73e-17 m=1
\+10 (gnd! 5) capacitor c=1.5887e-16 m=1
\+9 (A gnd!) capacitor c=2.6905e-17 m=1
\+8 (vdd! 5) capacitor c=3.084e-17 m=1
\+7 (vdd! gnd!) capacitor c=1.0258e-16 m=1
\+6 (vdd! A) capacitor c=2.6905e-17 m=1
\+5 (INV2OUT gnd!) capacitor c=1.32745e-16 m=1
\+4 (INV2OUT vdd!) capacitor c=6.4025e-17 m=1
\+1 (5 INV2OUT gnd! gnd!) tsmc20N w=3e-07 l=2e-07 as=1.9e-13 ad=1.9e-13 ps=1.5e-06 pd=1.5e-06 m=1 region=sat
\+0 (INV2OUT A gnd! gnd!) tsmc20N w=1.6e-06 l=2e-07 as=8e-13 ad=8e-13 ps=2.6e-06 pd=2.6e-06 m=1 region=sat
\+2 (INV2OUT A vdd! vdd!) tsmc20P w=1.6e-06 l=2e-07 as=8e-13 ad=8e-13 ps=2.6e-06 pd=2.6e-06 m=1 region=sat
simulatorOptions options reltol=1e-3 vabstol=1e-6 iabstol=1e-12 temp=27 \
    tnom=27 scalem=1.0 scale=1.0 gmin=1e-12 rforce=1 maxnotes=5 maxwarns=5 \
    digits=5 cols=80 pivrel=1e-3 sensfile="../psf/sens.output" \
    checklimitdest=psf
modelParameter info what=models where=rawfile
element info what=inst where=rawfile
outputParameter info what=output where=rawfile
designParamVals info what=parameters where=rawfile
primitives info what=primitives where=rawfile
subckts info what=subckts  where=rawfile
saveOptions options save=allpub
