// Generated for: spectre
// Generated on: Nov  9 12:30:34 2016
// Design library name: lab2
// Design cell name: DFF
// Design view name: extracted
simulator lang=spectre
global 0

// Library name: lab2
// Cell name: DFF
// View name: extracted
\+27 (19 Q vdd! vdd!) tsmc20P w=4e-07 l=2e-07 as=2e-13 ad=2e-13 ps=1.4e-06 \
        pd=1.4e-06 m=1 region=sat
\+24 (18 \~clock 17 vdd!) tsmc20P w=4e-07 l=2e-07 as=2e-13 ad=2e-13 \
        ps=1.4e-06 pd=1.4e-06 m=1 region=sat
\+23 (18 clock 16 vdd!) tsmc20P w=4e-07 l=2e-07 as=2e-13 ad=2e-13 \
        ps=1.4e-06 pd=1.4e-06 m=1 region=sat
\+22 (16 15 vdd! vdd!) tsmc20P w=4e-07 l=2e-07 as=2e-13 ad=2e-13 \
        ps=1.4e-06 pd=1.4e-06 m=1 region=sat
\+20 (15 \~clock NAND2INVOUT vdd!) tsmc20P w=4e-07 l=2e-07 as=2e-13 \
        ad=2e-13 ps=1.4e-06 pd=1.4e-06 m=1 region=sat
\+19 (15 clock 11 vdd!) tsmc20P w=4e-07 l=2e-07 as=2e-13 ad=2e-13 \
        ps=1.4e-06 pd=1.4e-06 m=1 region=sat
\+16 (NAND2INVOUT 14 vdd! vdd!) tsmc20P w=4e-07 l=2e-07 as=2e-13 ad=2e-13 \
        ps=1.4e-06 pd=1.4e-06 m=1 region=sat
\+15 (12 Load 11 vdd!) tsmc20P w=4e-07 l=2e-07 as=2e-13 ad=2e-13 \
        ps=1.4e-06 pd=1.4e-06 m=1 region=sat
\+14 (12 \~Load D vdd!) tsmc20P w=4e-07 l=2e-07 as=2e-13 ad=2e-13 \
        ps=1.4e-06 pd=1.4e-06 m=1 region=sat
\+115 (gnd! 18) capacitor c=2.328e-17 m=1
\+114 (gnd! 16) capacitor c=2.328e-17 m=1
\+113 (gnd! 15) capacitor c=7.76e-17 m=1
\+112 (gnd! 14) capacitor c=7.76e-17 m=1
\+111 (gnd! 12) capacitor c=5.917e-17 m=1
\+110 (\~clock gnd!) capacitor c=5.82e-17 m=1
\+109 (Q gnd!) capacitor c=1.0088e-16 m=1
\+108 (Load gnd!) capacitor c=2.91e-17 m=1
\+107 (clock gnd!) capacitor c=5.82e-17 m=1
\+106 (vdd! 18) capacitor c=2.328e-17 m=1
\+105 (vdd! 16) capacitor c=2.328e-17 m=1
\+104 (vdd! \~clock) capacitor c=4.268e-17 m=1
\+103 (vdd! Q) capacitor c=3.88e-17 m=1
\+102 (vdd! Load) capacitor c=2.134e-17 m=1
\+101 (vdd! clock) capacitor c=4.268e-17 m=1
\+100 (\~Load gnd!) capacitor c=2.91e-17 m=1
\+99 (\~Load vdd!) capacitor c=2.134e-17 m=1
\+98 (reset gnd!) capacitor c=5.917e-17 m=1
\+97 (12 14) capacitor c=6.966e-17 m=1
\+96 (gnd! 19) capacitor c=1.35e-16 m=1
\+95 (gnd! 18) capacitor c=3.0624e-16 m=1
\+94 (gnd! 17) capacitor c=1.8891e-16 m=1
\+93 (gnd! 16) capacitor c=2.9345e-16 m=1
\+92 (gnd! 15) capacitor c=3.0624e-16 m=1
\+91 (gnd! 14) capacitor c=1.75685e-16 m=1
\+90 (gnd! 12) capacitor c=3.0624e-16 m=1
\+89 (gnd! 11) capacitor c=3.3906e-16 m=1
\+88 (NAND2INVOUT gnd!) capacitor c=3.4206e-16 m=1
\+87 (Q gnd!) capacitor c=9.141e-17 m=1
\+86 (D gnd!) capacitor c=1.7977e-16 m=1
\+85 (vdd! 19) capacitor c=3.084e-17 m=1
\+84 (vdd! 18) capacitor c=9.046e-17 m=1
\+83 (vdd! 17) capacitor c=8.003e-17 m=1
\+82 (vdd! 16) capacitor c=8.445e-17 m=1
\+81 (vdd! 15) capacitor c=9.046e-17 m=1
\+80 (vdd! 14) capacitor c=9.5675e-17 m=1
\+79 (vdd! 12) capacitor c=9.046e-17 m=1
\+78 (vdd! 11) capacitor c=1.213e-16 m=1
\+77 (vdd! gnd!) capacitor c=1.18588e-15 m=1
\+76 (vdd! NAND2INVOUT) capacitor c=7.607e-17 m=1
\+75 (vdd! Q) capacitor c=5.2875e-17 m=1
\+74 (vdd! D) capacitor c=4.523e-17 m=1
\+73 (reset 14) capacitor c=6.966e-17 m=1
\+72 (11 16) capacitor c=3.2263e-16 m=1
\+71 (11 15) capacitor c=1.5924e-16 m=1
\+70 (11 12) capacitor c=7.268e-17 m=1
\+69 (gnd! 18) capacitor c=5.8004e-16 m=1
\+68 (gnd! 16) capacitor c=2.58825e-16 m=1
\+67 (gnd! 15) capacitor c=6.2106e-16 m=1
\+66 (gnd! 14) capacitor c=5.5828e-16 m=1
\+65 (gnd! 12) capacitor c=4.4705e-16 m=1
\+64 (gnd! 11) capacitor c=3.1447e-16 m=1
\+63 (NAND2INVOUT 14) capacitor c=6.186e-17 m=1
\+62 (\~clock 11) capacitor c=1.376e-16 m=1
\+61 (\~clock gnd!) capacitor c=2.7726e-16 m=1
\+60 (\~clock NAND2INVOUT) capacitor c=4.1892e-16 m=1
\+59 (Q 17) capacitor c=7.325e-17 m=1
\+58 (Q gnd!) capacitor c=4.09693e-16 m=1
\+57 (vdd! 16) capacitor c=8.9025e-17 m=1
\+56 (vdd! 11) capacitor c=1.6349e-16 m=1
\+55 (vdd! \~clock) capacitor c=4.82e-17 m=1
\+54 (\~Load 11) capacitor c=1.376e-16 m=1
\+53 (\~Load gnd!) capacitor c=2.7726e-16 m=1
\+52 (\~Load D) capacitor c=4.1892e-16 m=1
\+51 (\~Load vdd!) capacitor c=4.82e-17 m=1
\+50 (17 18) capacitor c=4.197e-17 m=1
\+49 (11 14) capacitor c=4.197e-17 m=1
\+48 (11 12) capacitor c=5.12805e-16 m=1
\+47 (gnd! 17) capacitor c=2.12745e-16 m=1
\+46 (gnd! 11) capacitor c=2.80245e-16 m=1
\+45 (\~clock 17) capacitor c=4.197e-17 m=1
\+44 (\~clock 16) capacitor c=6.53845e-16 m=1
\+43 (\~clock 15) capacitor c=7.051e-17 m=1
\+42 (\~clock gnd!) capacitor c=3.97855e-16 m=1
\+41 (Q 17) capacitor c=8.886e-17 m=1
\+40 (Load 11) capacitor c=5.87e-17 m=1
\+39 (Load gnd!) capacitor c=4.0923e-16 m=1
\+38 (clock 18) capacitor c=5.3401e-16 m=1
\+37 (clock 16) capacitor c=7.051e-17 m=1
\+36 (clock 15) capacitor c=4.249e-17 m=1
\+35 (clock 11) capacitor c=1.0825e-16 m=1
\+34 (clock gnd!) capacitor c=5.8117e-16 m=1
\+33 (clock \~clock) capacitor c=1.2634e-16 m=1
\+32 (vdd! 17) capacitor c=9.431e-17 m=1
\+31 (vdd! \~clock) capacitor c=2.94975e-16 m=1
\+30 (vdd! clock) capacitor c=3.1783e-16 m=1
\+29 (\~Load Load) capacitor c=1.2634e-16 m=1
\+28 (reset 11) capacitor c=2.854e-17 m=1
\+13 (19 Q gnd! gnd!) tsmc20N w=4e-07 l=2e-07 as=2e-13 ad=2e-13 ps=1.4e-06 \
        pd=1.4e-06 m=1 region=sat
\+10 (18 clock 17 gnd!) tsmc20N w=4e-07 l=2e-07 as=2e-13 ad=2e-13 \
        ps=1.4e-06 pd=1.4e-06 m=1 region=sat
\+9 (18 \~clock 16 gnd!) tsmc20N w=4e-07 l=2e-07 as=2e-13 ad=2e-13 \
        ps=1.4e-06 pd=1.4e-06 m=1 region=sat
\+8 (16 15 gnd! gnd!) tsmc20N w=4e-07 l=2e-07 as=2e-13 ad=2e-13 ps=1.4e-06 \
        pd=1.4e-06 m=1 region=sat
\+6 (15 \~clock 11 gnd!) tsmc20N w=4e-07 l=2e-07 as=2e-13 ad=2e-13 \
        ps=1.4e-06 pd=1.4e-06 m=1 region=sat
\+5 (15 clock NAND2INVOUT gnd!) tsmc20N w=4e-07 l=2e-07 as=2e-13 ad=2e-13 \
        ps=1.4e-06 pd=1.4e-06 m=1 region=sat
\+4 (14 reset 13 gnd!) tsmc20N w=4e-07 l=2e-07 as=1.2e-13 ad=2e-13 \
        ps=6e-07 pd=1.4e-06 m=1 region=sat
\+3 (NAND2INVOUT 14 gnd! gnd!) tsmc20N w=4e-07 l=2e-07 as=2e-13 ad=2e-13 \
        ps=1.4e-06 pd=1.4e-06 m=1 region=sat
\+2 (13 12 gnd! gnd!) tsmc20N w=4e-07 l=2e-07 as=2e-13 ad=1.2e-13 \
        ps=1.4e-06 pd=6e-07 m=1 region=sat
\+1 (12 \~Load 11 gnd!) tsmc20N w=4e-07 l=2e-07 as=2e-13 ad=2e-13 \
        ps=1.4e-06 pd=1.4e-06 m=1 region=sat
\+0 (12 Load D gnd!) tsmc20N w=4e-07 l=2e-07 as=2e-13 ad=2e-13 ps=1.4e-06 \
        pd=1.4e-06 m=1 region=sat
\+12 (17 Q gnd! gnd!) tsmc20N w=1.6e-06 l=2e-07 as=8e-13 ad=8e-13 \
        ps=2.6e-06 pd=2.6e-06 m=1 region=sat
\+11 (Q 18 gnd! gnd!) tsmc20N w=1.6e-06 l=2e-07 as=8e-13 ad=8e-13 \
        ps=2.6e-06 pd=2.6e-06 m=1 region=sat
\+7 (11 16 gnd! gnd!) tsmc20N w=1.6e-06 l=2e-07 as=8e-13 ad=8e-13 \
        ps=2.6e-06 pd=2.6e-06 m=1 region=sat
\+26 (17 Q vdd! vdd!) tsmc20P w=1.6e-06 l=2e-07 as=8e-13 ad=8e-13 \
        ps=2.6e-06 pd=2.6e-06 m=1 region=sat
\+25 (Q 18 vdd! vdd!) tsmc20P w=1.6e-06 l=2e-07 as=8e-13 ad=8e-13 \
        ps=2.6e-06 pd=2.6e-06 m=1 region=sat
\+21 (11 16 vdd! vdd!) tsmc20P w=1.6e-06 l=2e-07 as=8e-13 ad=8e-13 \
        ps=2.6e-06 pd=2.6e-06 m=1 region=sat
\+18 (14 reset vdd! vdd!) tsmc20P w=8.5e-07 l=2e-07 as=2.55e-13 \
        ad=4.25e-13 ps=6e-07 pd=1.85e-06 m=1 region=sat
\+17 (vdd! 12 14 vdd!) tsmc20P w=8.5e-07 l=2e-07 as=4.25e-13 ad=2.55e-13 \
        ps=1.85e-06 pd=6e-07 m=1 region=sat
simulatorOptions options reltol=1e-3 vabstol=1e-6 iabstol=1e-12 temp=27 \
    tnom=27 scalem=1.0 scale=1.0 gmin=1e-12 rforce=1 maxnotes=5 maxwarns=5 \
    digits=5 cols=80 pivrel=1e-3 sensfile="../psf/sens.output" \
    checklimitdest=psf
modelParameter info what=models where=rawfile
element info what=inst where=rawfile
outputParameter info what=output where=rawfile
designParamVals info what=parameters where=rawfile
primitives info what=primitives where=rawfile
subckts info what=subckts  where=rawfile
saveOptions options save=allpub
