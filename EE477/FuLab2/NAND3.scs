// Generated for: spectre
// Generated on: Nov  7 19:16:55 2016
// Design library name: lab1
// Design cell name: NAND3test
// Design view name: extracted
simulator lang=spectre
global 0

// Library name: lab1
// Cell name: NAND3test
// View name: extracted
\+7 (9 NAND3OUT vdd! vdd!) tsmc20P w=4e-07 l=2e-07 as=2e-13 ad=2e-13 \
        ps=1.4e-06 pd=1.4e-06 m=1 region=sat
\+18 (NAND3OUT gnd!) capacitor c=7.566e-17 m=1
\+17 (C gnd!) capacitor c=6.402e-17 m=1
\+16 (B gnd!) capacitor c=6.402e-17 m=1
\+15 (A gnd!) capacitor c=6.402e-17 m=1
\+14 (gnd! 9) capacitor c=1.5887e-16 m=1
\+13 (NAND3OUT gnd!) capacitor c=2.1034e-16 m=1
\+12 (B NAND3OUT) capacitor c=6.966e-17 m=1
\+11 (A NAND3OUT) capacitor c=6.966e-17 m=1
\+10 (vdd! 9) capacitor c=3.084e-17 m=1
\+9 (vdd! gnd!) capacitor c=1.5808e-16 m=1
\+8 (vdd! NAND3OUT) capacitor c=6.168e-17 m=1
\+3 (9 NAND3OUT gnd! gnd!) tsmc20N w=4e-07 l=2e-07 as=2e-13 ad=2e-13 \
        ps=1.4e-06 pd=1.4e-06 m=1 region=sat
\+2 (NAND3OUT A 8 gnd!) tsmc20N w=4e-07 l=2e-07 as=1.2e-13 ad=2e-13 \
        ps=6e-07 pd=1.4e-06 m=1 region=sat
\+1 (8 B 7 gnd!) tsmc20N w=4e-07 l=2e-07 as=1.2e-13 ad=1.2e-13 ps=6e-07 \
        pd=6e-07 m=1 region=sat
\+0 (7 C gnd! gnd!) tsmc20N w=4e-07 l=2e-07 as=2e-13 ad=1.2e-13 ps=1.4e-06 \
        pd=6e-07 m=1 region=sat
\+6 (NAND3OUT A vdd! vdd!) tsmc20P w=6e-07 l=2e-07 as=1.8e-13 ad=3e-13 \
        ps=6e-07 pd=1.6e-06 m=1 region=sat
\+5 (vdd! B NAND3OUT vdd!) tsmc20P w=6e-07 l=2e-07 as=1.8e-13 ad=1.8e-13 \
        ps=6e-07 pd=6e-07 m=1 region=sat
\+4 (NAND3OUT C vdd! vdd!) tsmc20P w=6e-07 l=2e-07 as=3e-13 ad=1.8e-13 \
        ps=1.6e-06 pd=6e-07 m=1 region=sat
simulatorOptions options reltol=1e-3 vabstol=1e-6 iabstol=1e-12 temp=27 \
    tnom=27 scalem=1.0 scale=1.0 gmin=1e-12 rforce=1 maxnotes=5 maxwarns=5 \
    digits=5 cols=80 pivrel=1e-3 sensfile="../psf/sens.output" \
    checklimitdest=psf
modelParameter info what=models where=rawfile
element info what=inst where=rawfile
outputParameter info what=output where=rawfile
designParamVals info what=parameters where=rawfile
primitives info what=primitives where=rawfile
subckts info what=subckts  where=rawfile
saveOptions options save=allpub
